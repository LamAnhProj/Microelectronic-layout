* SKY130A two-transistor inverter; TT, 25 C, 1.8 V.
* Requires the Volare-enabled PDK mounted at /pdk in the worker.
.lib /pdk/sky130A/libs.tech/ngspice/sky130.lib.spice tt
.temp 25

VDD vdd 0 1.8
VIN in 0 PULSE(0 1.8 1n 20p 20p 2n 4n)
XMN out in 0 0 sky130_fd_pr__nfet_01v8 w=1 l=0.15
XMP out in vdd vdd sky130_fd_pr__pfet_01v8 w=2 l=0.15
CLOAD out 0 5f

.tran 2p 12n
.meas tran vout_high FIND v(out) AT=0.5n
.meas tran vout_low FIND v(out) AT=2n
.meas tran tphl TRIG v(in) VAL=0.9 RISE=1 TARG v(out) VAL=0.9 FALL=1
.meas tran tplh TRIG v(in) VAL=0.9 FALL=1 TARG v(out) VAL=0.9 RISE=1
.end
